** Profile: "SCHEMATIC1-time"  [ E:\orcad\Oscillator\Oscillator-PSpiceFiles\SCHEMATIC1\time.sim ]

** Creating circuit file "time.cir"
** WARNING: THIS AUTOMATICALLY GENERATED FILE MAY BE OVERWRITTEN BY SUBSEQUENT SIMULATIONS

*Libraries:
* Profile Libraries :
.INC "E:\orcad\Oscillator\Oscillator-PSpiceFiles\SCHEMATIC1\time\time_profile.inc"
* Local Libraries :
* From [PSPICE NETLIST] section of C:\SPB_Data\cdssetup\OrCAD_PSpice\17.2.0\PSpice.ini file:
.lib "nomd.lib"

*Analysis directives:
.TRAN  0 2.5 2.4 0.01m SKIPBP
.OPTIONS ADVCONV
.PROBE64 V(alias(*)) I(alias(*)) W(alias(*)) D(alias(*)) NOISE(alias(*))
.INC "..\SCHEMATIC1.net"

.END
